ADE simulation setup
Run mode: Single Run, Sweeps and Corners
Tests:
  SRAM_PVT:6T_rwtrans_tb:1 (off): SRAM_PVT/6T_rwtrans_tb/schematic, simulator spectre
  SRAM_PVT:6T__opt_write_rwtrans_tb:1 (off): SRAM_PVT/6T__opt_write_rwtrans_tb/schematic, simulator spectre
  SRAM_PVT:6T_opt_read_rwtrans_tb:1: SRAM_PVT/6T_opt_read_rwtrans_tb/schematic, simulator spectre
Global variables:
  VDD = 1
  WPG = 120n
  WPD = 180n
  WPU = 120n
Corners (nominal off):
  model folders: /lcars/software/linux/x86_64/ic-design/design_kits/gpdk045_v_6_0/gpdk045/../models/spectre
  C0: temperature=27; VDD=1; WPD=180n; WPG=120n; WPU=120n; gpdk045.scs[tt]
