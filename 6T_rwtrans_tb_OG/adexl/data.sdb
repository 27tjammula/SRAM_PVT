ADE simulation setup
Run mode: Single Run, Sweeps and Corners
Tests:
  SRAM_PVT:6T_rwtrans_tb:1 (off): SRAM_PVT/6T_rwtrans_tb/schematic, simulator spectre
    Outputs: /V0/PLUS
  SRAM_PVT:6T_readSNM_tb:1: SRAM_PVT/6T_readSNM_tb/schematic, simulator spectre
Global variables:
  VDD = 1
  WPD = 180n
  WPG = 120n
  WPU = 120n
Corners (nominal off):
  model folders: /lcars/software/linux/x86_64/ic-design/design_kits/gpdk045_v_6_0/gpdk045/../models/spectre
  C0_ss: temperature=85; VDD=1.2; gpdk045.scs[ff]
