ADE simulation setup
Test SRAM_PVT:6T_bitcell_testbench:1: SRAM_PVT/6T_bitcell_testbench/schematic, simulator spectre
  Models: /lcars/software/linux/x86_64/ic-design/design_kits/gpdk045_v_6_0/gpdk045/../models/spectre/gpdk045.scs[mc]
  Temperature: 27
  Analysis tran: stop=20n
  Signals: /Q, /QB, /BL, /BLB
