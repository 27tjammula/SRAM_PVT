ADE simulation setup
Test SRAM_PVT:6T_bitcell_testbench:1: SRAM_PVT/6T_bitcell_testbench/schematic, simulator spectre
  Models: /lcars/software/linux/x86_64/ic-design/design_kits/gpdk045_v_6_0/gpdk045/../models/spectre/gpdk045.scs[mc]
  Temperature: 27
  Analysis tran: stop=20n
  Signals: /Q, /QB, /BL, /BLB
Test SRAM_PVT:6T_bitcell_testbench:2: SRAM_PVT/6T_bitcell_testbench/schematic, simulator spectre
  Models: /lcars/software/linux/x86_64/ic-design/design_kits/gpdk045_v_6_0/gpdk045/../models/spectre/gpdk045.scs[mc]
  Variables: VDD = 1; WPD = 180n; WPG = 120n; WPU = 120n
  Temperature: 27
  Analysis dc: sweep /V1.dc start=0 stop=1
  Signals: /Q, /QB
