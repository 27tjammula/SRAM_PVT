ADE simulation setup
Run mode: Single Run, Sweeps and Corners
Tests:
  SRAM_PVT:6T_bitcell_testbench:1: SRAM_PVT/6T_bitcell_testbench/schematic, simulator spectre
    Outputs: "/V(\"\\Q\")"; "/V(\"/Q\")"; "/"; /V("/QB"); /; /Q; /QB; /BL; /BLB
  SRAM_PVT:6T_bitcell_testbench:2: SRAM_PVT/6T_bitcell_testbench/schematic, simulator spectre
    Variables: VDD = 1; WPD = 180n; WPG = 120n; WPU = 120n
Global variables:
  VDD = 1.0
  WPD = 180n
  WPG = 120n
  WPU = 120n
Corners (nominal off):
  model folders: /lcars/software/linux/x86_64/ic-design/design_kits/gpdk045_v_6_0/gpdk045/../models/spectre
  C0_tt: temperature=27; VDD=1; gpdk045.scs[tt]
  C1_ss (off): temperature=85; VDD=1
  C2_tt (off): temperature=85; VDD=1.2
