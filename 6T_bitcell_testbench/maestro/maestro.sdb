ADE simulation setup
Run mode: Single Run, Sweeps and Corners
Tests:
  SRAM_PVT:6T_bitcell_testbench:1: SRAM_PVT/6T_bitcell_testbench/schematic, simulator spectre
    Outputs: "/V(\"\\Q\")"; "/V(\"/Q\")"; "/"; /V("/QB"); /; /Q; /QB; /BL; /BLB
Global variables:
  VDD = 1.0
  WPD = 180n
  WPG = 120n
  WPU = 120n
Corners (nominal off):
  model folders: /lcars/software/linux/x86_64/ic-design/design_kits/gpdk045_v_6_0/gpdk045/../models/spectre
  C0_tt: temperature=27; gpdk045.scs[tt]
  C1_tt (off): temperature=85; gpdk045.scs[tt]
  C2_tt (off): temperature=0; gpdk045.scs[tt]
  C3_ff (off): temperature=27; gpdk045.scs[ff]
  C4_ff (off): temperature=85; gpdk045.scs[ff]
  C5_ff (off): temperature=0; gpdk045.scs[ff]
  C6_ss (off): temperature=27; gpdk045.scs[ss]
  C7_ss (off): temperature=85; gpdk045.scs[ss]
  C8_ss (off): temperature=0; gpdk045.scs[ss]
