ADE simulation setup
Run mode: Single Run, Sweeps and Corners
Tests:
  SRAM_PVT:6T_bitcell_testbench:1: SRAM_PVT/6T_bitcell_testbench/schematic, simulator spectre
Global variables:
  VDD = 1
  WPD = 120n
  WPG = 120n
  WPU = 120n
Corners (nominal off):
  model folders: /lcars/software/linux/x86_64/ic-design/design_kits/gpdk045_v_6_0/gpdk045/../models/spectre
  C0: temperature=0; VDD=1; gpdk045.scs[ff]
  C1: temperature=0; VDD=0.8; gpdk045.scs[ff]
  C2 (off): temperature=85; VDD=0.8
